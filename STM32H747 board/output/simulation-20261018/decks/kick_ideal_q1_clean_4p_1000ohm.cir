STM32H747 representative ADC review: kick_ideal_q1_clean_4p_1000ohm
* TI vendor model compatibility run in ngspice 47, NOT Cadence PSpice.
* CAD files unchanged; see source-audit.json and model-index.json.
.include "C:/Dev/EasyEDA/EasyEDA-Project/STM32H747 board/output/simulation-20261018/models/OPA189/OPAx189.LIB"
.include "C:/Dev/EasyEDA/EasyEDA-Project/STM32H747 board/output/simulation-20261018/models/OPA320/OPAx320-Q1.LIB"
.options reltol=1e-5 abstol=1e-12 vntol=1e-7 itl1=500 itl4=1000 method=gear
.temp 27
.include "C:/Dev/EasyEDA/EasyEDA-Project/STM32H747 board/output/simulation-20261018/runtime/warm-start-ideal-j2-internal.inc"

V5 v5 0 DC 5
V3 v3 0 DC 3.3
VN vn3 0 DC -3.01244
R200 v5 v5afe 4.7
C156 v5afe 0 4.7u
C157 v5afe 0 4.7u
* Nine unsimulated front buffers: explicit nominal 1.3mA DC rail load EACH.
* This load is an assumption, not a full ten-channel coupling simulation.
Iother v5afe vn3 11.7m
Voff off 0 DC 0.968992248062

Vprev prev 0 DC 3.0472868217
Vtrack track 0 PULSE(0 1 10u 1n 1n 8u 21.3675213675u)
Vpre pre 0 PULSE(1 0 9.9u 1n 1n 8.2u 21.3675213675u)
Ssample adc_j2 sample track 0 SW_ACQ
Spre sample prev pre 0 SW_PRE
.model SW_ACQ SW(Ron=1000 Roff=1e14 Vt=.5 Vh=0)
.model SW_PRE SW(Ron=10 Roff=1e14 Vt=.5 Vh=0)
Cs sample 0 4p

* Actual J2 values; source resistance is generator, not board termination.
Vsig_j2 src_j2 0 DC 2.001
Rsource_j2 src_j2 raw_j2 50
R177_j2 raw_j2 0 100000
R140_j2 raw_j2 filt_j2 3320
C97_j2 filt_j2 0 10n
XU20_j2 filt_j2 buf_j2 v5afe vn3 buf_j2 OPAx189
C120_j2 v5afe 0 100n
C121_j2 vn3 0 100n
R137_j2 buf_j2 sum_j2 4000
XU10_j2 off sum_j2 v3 0 drv_j2 OPAx320-Q1
C100_j2 v3 0 100n
R187_j2 sum_j2 drv_j2 2800
C122_j2 sum_j2 drv_j2 10n
R141_j2 drv_j2 adc_j2 47
C80_j2 adc_j2 0 10n

.save v(raw_j2) v(filt_j2) v(buf_j2) v(drv_j2) v(adc_j2) v(off) v(ref25) v(v5afe) i(v5) i(v3) i(vn) v(sample) v(track) v(pre)
.tran 1n 100u 0 1n
.end
