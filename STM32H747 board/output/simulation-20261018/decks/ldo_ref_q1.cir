STM32H747 representative ADC review: ldo_ref_q1
* TI vendor model compatibility run in ngspice 47, NOT Cadence PSpice.
* CAD files unchanged; see source-audit.json and model-index.json.
.include "C:/Dev/EasyEDA/EasyEDA-Project/STM32H747 board/output/simulation-20261018/models/TPS72301/TPS72301.LIB"
.options reltol=1e-5 abstol=1e-12 vntol=1e-7 itl1=500 itl4=1000
.temp 27

Vraw raw 0 PWL(0 0 1m 0 2m -4.5)
XU31 0 raw raw fb neg TPS72301
R198 neg fb 15.4k
R199 0 fb 10k
C155 fb neg 10n
C153 neg 0 4.7u
C154 neg 0 4.7u
* Positive current into negative rail simulates ten 1.3mA front-buffer returns.
Iload 0 neg 13m

.save v(raw) v(neg) v(fb) i(vraw)
.tran 1u 20m 0 1u
.end
