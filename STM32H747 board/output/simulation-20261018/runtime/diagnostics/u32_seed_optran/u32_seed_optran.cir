Original TI OPA189 standalone U32, single 5 V rail, 0.969 V follower
.include "C:/Dev/EasyEDA/EasyEDA-Project/STM32H747 board/output/simulation-20261018/models/OPA189/OPAx189.LIB"
.options reltol=1e-5 abstol=1e-12 vntol=1e-7 itl1=500 itl4=1000
.temp 27
VP vp 0 5
VI vi 0 0.969
XU32 vi off vp 0 off OPAx189
RL off 0 1meg
.save all
.op
.end
