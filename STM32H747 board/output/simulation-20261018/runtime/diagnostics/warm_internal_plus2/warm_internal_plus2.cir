STM32H747 representative ADC review: smoke_ideal_q1
* TI vendor model compatibility run in ngspice 47, NOT Cadence PSpice.
* CAD files unchanged; see source-audit.json and model-index.json.
.include "C:/Dev/EasyEDA/EasyEDA-Project/STM32H747 board/output/simulation-20261018/models/OPA189/OPAx189.LIB"
.include "C:/Dev/EasyEDA/EasyEDA-Project/STM32H747 board/output/simulation-20261018/models/OPA320/OPAx320-Q1.LIB"
.save @c97_j2[i] @c122_j2[i] @c80_j2[i] @c156[i] @c157[i]
.options reltol=1e-5 abstol=1e-12 vntol=1e-7 itl1=500 itl4=1000
.nodeset v(xu20_j2.n3294772)=0.0005460403466550763
.nodeset v(xu20_j2.n2991553)=0.00055572319957552456
.nodeset v(xu20_j2.n3294626)=-0.1044959979046058
.nodeset v(xu20_j2.n3294630)=-0.032503154884561958
.nodeset v(xu20_j2.n2992397)=4.9388950565822078
.nodeset v(xu20_j2.n2992375)=0.0005557249390679966
.nodeset v(xu20_j2.n2992413)=-3.012436983992254
.nodeset v(xu20_j2.n2991741)=0.00055572493906805634
.nodeset v(xu20_j2.mid)=0.0005557249390679966
.nodeset v(xu20_j2.n2991765)=0.00055572493906805634
.nodeset v(xu20_j2.n2991811)=0.00055572493906805634
.nodeset v(xu20_j2.n2991831)=0.00055572493906805634
.nodeset v(xu20_j2.n3294812)=-1.760538492153692
.nodeset v(xu20_j2.n2991579)=0.00055560029974444092
.nodeset v(xu20_j2.n2991907)=0.00055572493906805634
.nodeset v(xu20_j2.n2991925)=0.00055572493906805634
.nodeset v(xu20_j2.n2991969)=-0.001197076734815833
.nodeset v(xu20_j2.n2992033)=4.9263944266707016
.nodeset v(xu20_j2.n2992029)=-2.9687288736078279
.nodeset v(xu20_j2.n2992093)=0.00055572163246807706
.nodeset v(xu20_j2.n2992099)=0.00055572128176779303
.nodeset v(xu20_j2.sw_ol_opax189)=0.0005557249390679966
.nodeset v(xu20_j2.vimon)=-0.24170023879591951
.nodeset v(xu20_j2.vout_s)=-1.496352286319085e-06
.nodeset v(xu20_j2.n2991657)=-1.501376069854834e-06
.nodeset v(xu20_j2.clamp)=-0.0011970767112487819
.nodeset v(xu20_j2.vclp)=-0.0011969276612030311
.nodeset v(xu20_j2.n4031911)=-0.0011969298089559181
.nodeset v(xu20_j2.n3827259)=-12.11860377294542
.nodeset v(xu20_j2.n3828449)=-0.060040125307865733
.nodeset v(xu20_j2.n3850714)=0.00058236727952720095
.nodeset v(xu20_j2.n3850724)=0.00055619094267311386
.nodeset v(xu20_j2.n3850734)=0.0026970114831748049
.nodeset v(xu20_j2.n3850744)=0.00055619096729442319
.nodeset v(xu20_j2.n39464171)=-0.0011959461169014369
.nodeset v(xu20_j2.n39483181)=-0.001196766959032736
.nodeset v(xu20_j2.n3957003)=-12.11979067884719
.nodeset v(xu20_j2.n3957013)=-1.7568976932099101
.nodeset v(xu20_j2.n4029618)=-0.0017663424619364829
.nodeset v(xu20_j2.n4029628)=-0.0011969319290500639
.nodeset v(xu20_j2.n3294524)=-0.001196927705947942
.nodeset v(xu20_j2.n40409811)=-12.120875917090061
.nodeset v(xu20_j2.n4053611)=0.00055685459148158145
.nodeset v(xu20_j2.n2991581)=0.00055619091022957035
.nodeset v(xu20_j2.n40636261)=-12.120825362780421
.nodeset v(xu20_j2.n40688271)=-12.1198096287907
.nodeset v(xu20_j2.n40719131)=-12.11980962589408
.nodeset v(xu20_j2.esdp)=-2.2186959538513961e-07
.nodeset v(xu20_j2.esdn)=-1.496370549594367e-06
.nodeset v(xu20_j2.n2992163)=-1.4963713035549461e-06
.nodeset v(xu20_j2.n3294618)=-0.001196927705947952
.nodeset v(xu20_j2.cl_clamp)=-0.001196927705947952
.nodeset v(xu20_j2.claw_clamp)=-0.001196927705947952
.nodeset v(xu20_j2.n3201092)=-12.121044559979
.nodeset v(xu20_j2.vcc_b)=4.9388950615205456
.nodeset v(xu20_j2.vee_b)=-3.012436987005247
.nodeset v(xu20_j2.n2991563)=-2.092039087709992e-06
.nodeset v(xu20_j2.n2991555)=-2.09029959538514e-06
.nodeset v(xu20_j2.vcc_clp)=4.9263944217448641
.nodeset v(xu20_j2.vee_clp)=-2.968728870638544
.nodeset v(xu20_j2.n2992299)=-3.301196924354604
.nodeset v(xu20_j2.n2992295)=-3.301196927661203
.nodeset v(xu20_j2.n2992323)=3.648803068681497
.nodeset v(xu20_j2.n2992331)=3.6488030723387972
.nodeset v(xu20_j2.n2992235)=-1.4963713035549461e-06
.nodeset v(xu20_j2.n3946385)=-0.0011970766446620801
.nodeset v(xu20_j2.vsense)=-0.0011970767348158089
.nodeset v(xu20_j2.n2991587)=-1.5014286027514869e-06
.nodeset v(xu20_j2.n2991583)=-2.092039087709992e-06
.nodeset v(xu20_j2.n3948252)=-0.001196847648713083
.nodeset v(xu20_j2.n3946395)=-0.0011968476541906259
.nodeset v(xu20_j2.n3957077)=-12.119809645995931
.nodeset v(xu20_j2.n3948270)=-0.001196821734458944
.nodeset v(xu20_j2.n4040957)=-12.120909645507311
.nodeset v(xu20_j2.n4040935)=-12.120909645667849
.nodeset v(xu20_j2.n4063590)=-12.120826968165691
.nodeset v(xu20_j2.n4068803)=-12.11980963223141
.nodeset v(xu20_j2.n4068781)=-12.11980963223175
.nodeset v(xu20_j2.n4071867)=-12.119809629316229
.nodeset v(xu20_j2.n2991573)=-2.2186959538513961e-07
.nodeset v(xu20_j2.n2991619)=-1.496370549594367e-06
.nodeset v(xu20_j2.n2991623)=2.438895061520546
.nodeset v(xu20_j2.n2991635)=-3.1124369870052471
.nodeset v(xu20_j2.n2991643)=-1.5013761223352509e-06
.nodeset v(xu20_j2.n2991667)=0.00055522438703051278
.nodeset v(xu20_j2.n3294682)=-12.11837195703847
.nodeset v(xu20_j2.n2991729)=0.00055572493906805634
.nodeset v(xu20_j2.n2991763)=0.00055572493906805634
.nodeset v(xu20_j2.n2991807)=69.400555724939068
.nodeset v(xu20_j2.n2991809)=0.00055572493906805634
.nodeset v(xu20_j2.n2991837)=0.00055572493906805634
.nodeset v(xu20_j2.n2991849)=-69.999444275060938
.nodeset v(xu20_j2.n2991901)=90.000555724939062
.nodeset v(xu20_j2.n2991905)=0.00055572493906805634
.nodeset v(xu20_j2.n2991931)=0.00055572493906805634
.nodeset v(xu20_j2.n2991943)=-89.999444275060938
.nodeset v(xu20_j2.n2991997)=4.9263944266707016
.nodeset v(xu20_j2.n2992001)=-2.9687288736078279
.nodeset v(xu20_j2.v11)=0.00055572163246807923
.nodeset v(xu20_j2.v12)=0.00055572128176779075
.nodeset v(xu20_j2.n2992105)=0.0005557249390679966
.nodeset v(xu20_j2.n2992151)=-0.241700240012201
.nodeset v(xu20_j2.n2992287)=3.648803068681497
.nodeset v(xu20_j2.n2992267)=-3.301196924354604
.nodeset v(xu20_j2.x_u10.gvo+_int1)=0
.nodeset v(xu20_j2.x_u10.gvo-_int1)=0
.nodeset v(xu20_j2.x_u11.gvo+_int1)=0
.nodeset v(xu20_j2.x_u11.gvo-_int1)=0
.nodeset v(xu20_j2.x_u12.gvo+_int1)=0
.nodeset v(xu20_j2.x_u12.gvo-_int1)=0
.nodeset v(xu20_j2.x_u16.gsw+_int1)=0
.nodeset v(xu20_j2.x_u18.g1_int1)=1.250063577546322e-05
.nodeset v(xu20_j2.x_u18.g1_int2)=-0.24225596373498751
.nodeset v(xu20_j2.x_u19.g1_int1)=4.3708113968212731e-05
.nodeset v(xu20_j2.x_u19.g1_int2)=0.24225596373498751
.nodeset v(xu20_j2.x_u22.g1_int1)=0
.nodeset v(xu20_j2.x_u23.g1_int1)=0
.nodeset v(xu20_j2.x_u26.g1_int1)=0
.nodeset v(xu20_j2.x_u27.g1_int1)=0.00024225596373498749
.nodeset v(xu20_j2.x_u30.g1_int1)=-5.0055202604668345e-13
.nodeset v(xu20_j2.x_u31.g1_int1)=-1.7910352563617509e-06
.nodeset v(xu20_j2.x_u32.g1_int1)=-12.119170049386749
.nodeset v(xu20_j2.x_u35.g1_int1)=0
.nodeset v(xu20_j2.x_u36.3)=0
.nodeset v(xu20_j2.x_u36.5)=0
.nodeset v(xu20_j2.x_u37.3)=0
.nodeset v(xu20_j2.x_u37.5)=0
.nodeset v(xu20_j2.x_u4.e1_int1)=-1.86843e-06
.nodeset v(xu20_j2.x_u40.5)=0
.nodeset v(xu20_j2.x_u6.g1_int1)=-0.00055722636767074809
.nodeset v(xu10_j2.n24458)=0.096841819383685107
.nodeset v(xu10_j2.n24659)=0.096089404030159031
.nodeset v(xu10_j2.n37029)=18.800623709004871
.nodeset v(xu10_j2.n37037)=18.625586900665191
.nodeset v(xu10_j2.mid)=0.096088424830413577
.nodeset v(xu10_j2.n39473)=29.874846194905221
.nodeset v(xu10_j2.n39884)=29.872153146405079
.nodeset v(xu10_j2.n39892)=2.9428911201614181
.nodeset v(xu10_j2.n2425309)=3.2999967928857892
.nodeset v(xu10_j2.n2425287)=0.096088424830413577
.nodeset v(xu10_j2.n2425325)=9.6184644563188994e-08
.nodeset v(xu10_j2.n56849)=0.096088424830423902
.nodeset v(xu10_j2.n57325)=0.096088424830423902
.nodeset v(xu10_j2.n59747)=0.096088424830423902
.nodeset v(xu10_j2.n59865)=0.096088424830423902
.nodeset v(xu10_j2.n25921)=-0.01665200947572568
.nodeset v(xu10_j2.n25929)=0.096087653087061908
.nodeset v(xu10_j2.n65579)=0.096088424830423902
.nodeset v(xu10_j2.n65697)=0.096088424830423902
.nodeset v(xu10_j2.n68774)=1.70212389780079
.nodeset v(xu10_j2.n72398)=3.28183632127344
.nodeset v(xu10_j2.n72391)=0.013387000238808179
.nodeset v(xu10_j2.n81574)=0.096088423908523554
.nodeset v(xu10_j2.n81664)=0.096088423908523582
.nodeset v(xu10_j2.sw_ol_opax320-q1)=0.096088424830413577
.nodeset v(xu10_j2.vclp)=1.702123933213525
.nodeset v(xu10_j2.vimon)=0.33834418443683489
.nodeset v(xu10_j2.n27785)=3.8513893899091589
.nodeset v(xu10_j2.n27793)=0.096104176062751345
.nodeset v(xu10_j2.vout_s)=1.6473381753920051
.nodeset v(xu10_j2.n2419074)=1.7021239076169321
.nodeset v(xu10_j2.n36262)=1.7021239300603981
.nodeset v(xu10_j2.n32347)=0.96902220012234319
.nodeset v(xu10_j2.n2821521)=0.096089403932495349
.nodeset v(xu10_j2.n2821796)=0.096088427180202107
.nodeset v(xu10_j2.clamp)=1.7021238974364299
.nodeset v(xu10_j2.esdp)=0.96899224806325446
.nodeset v(xu10_j2.esdn)=0.96902204643910561
.nodeset v(xu10_j2.n158495)=1.702123930060397
.nodeset v(xu10_j2.cl_clamp)=1.702123930060397
.nodeset v(xu10_j2.n161937)=1.64733817228444
.nodeset v(xu10_j2.claw_clamp)=1.7021239300603961
.nodeset v(xu10_j2.n45999)=1.64733817228444
.nodeset v(xu10_j2.n39124)=29.87484542535671
.nodeset v(xu10_j2.n39417)=29.874846072604441
.nodeset v(xu10_j2.vcc_b)=3.299996796089697
.nodeset v(xu10_j2.vee_b)=9.6088556234537757e-08
.nodeset v(xu10_j2.n25415)=0.9690056771465192
.nodeset v(xu10_j2.n25397)=0.96900469806325462
.nodeset v(xu10_j2.n25248)=0.096089403987299704
.nodeset v(xu10_j2.vcc_clp)=3.2818363180876928
.nodeset v(xu10_j2.vee_clp)=0.0133870003215096
.nodeset v(xu10_j2.n1356345)=0.78207393413541504
.nodeset v(xu10_j2.n1356333)=0.78207393321352492
.nodeset v(xu10_j2.n1356409)=2.6221739322916351
.nodeset v(xu10_j2.n1356429)=2.6221739332135252
.nodeset v(xu10_j2.vsense)=1.70212389780079
.nodeset v(xu10_j2.n28678)=0.96902220012220863
.nodeset v(xu10_j2.n28438)=0.9690056771465192
.nodeset v(xu10_j2.n24207)=0.96899224806325457
.nodeset v(xu10_j2.n31303)=0.96902204643910561
.nodeset v(xu10_j2.n31389)=3.399996796089698
.nodeset v(xu10_j2.n31737)=-0.099999903911443769
.nodeset v(xu10_j2.n32236)=0.96902220012234308
.nodeset v(xu10_j2.n32510)=0.096103793154199479
.nodeset v(xu10_j2.n46041)=29.871683331804832
.nodeset v(xu10_j2.n55560)=0.096088424830423888
.nodeset v(xu10_j2.n57321)=0.096088424830423888
.nodeset v(xu10_j2.n59739)=65.096088424830413
.nodeset v(xu10_j2.n59743)=0.096088424830423888
.nodeset v(xu10_j2.n59881)=0.096088424830423888
.nodeset v(xu10_j2.n59905)=-70.282911575169592
.nodeset v(xu10_j2.n65567)=100.0960884248304
.nodeset v(xu10_j2.n65575)=0.096088424830423888
.nodeset v(xu10_j2.n65713)=0.096088424830423888
.nodeset v(xu10_j2.n65737)=-114.9039115751696
.nodeset v(xu10_j2.n72064)=3.28183632127344
.nodeset v(xu10_j2.n72073)=0.01338700023880815
.nodeset v(xu10_j2.v11)=0.096088423908523554
.nodeset v(xu10_j2.v12)=0.096088423908523582
.nodeset v(xu10_j2.n81756)=0.096088424830413577
.nodeset v(xu10_j2.n161737)=0.33834418390457499
.nodeset v(xu10_j2.n1356115)=2.6221739322916351
.nodeset v(xu10_j2.n1356061)=0.78207393413541504
.nodeset v(xu10_j2.x_u1.7)=0.83378641264876896
.nodeset v(xu10_j2.x_u1.8)=0.83378641264876896
.nodeset v(xu10_j2.x_u1.3)=0
.nodeset v(xu10_j2.x_u1.6)=0
.nodeset v(xu10_j2.x_u1.4)=0
.nodeset v(xu10_j2.x_u1.5)=0
.nodeset v(xu10_j2.x_u10.gvo+_int1)=0
.nodeset v(xu10_j2.x_u10.gvo-_int1)=0
.nodeset v(xu10_j2.x_u11.gvo+_int1)=0
.nodeset v(xu10_j2.x_u11.gvo-_int1)=0
.nodeset v(xu10_j2.x_u12.gvo+_int1)=0
.nodeset v(xu10_j2.x_u12.gvo-_int1)=0
.nodeset v(xu10_j2.x_u16.gsw+_int1)=0
.nodeset v(xu10_j2.x_u18.g1_int1)=1.816047564102304e-05
.nodeset v(xu10_j2.x_u18.g1_int2)=0.24225575960642129
.nodeset v(xu10_j2.x_u19.g1_int1)=1.338690411875694e-05
.nodeset v(xu10_j2.x_u19.g1_int2)=-0.24225575960642129
.nodeset v(xu10_j2.x_u22.g1_int1)=0
.nodeset v(xu10_j2.x_u23.g1_int1)=0
.nodeset v(xu10_j2.x_u26.g1_int1)=0.00024225575960642131
.nodeset v(xu10_j2.x_u27.g1_int1)=0
.nodeset v(xu10_j2.x_u30.g1_int1)=1.5368323760399552e-11
.nodeset v(xu10_j2.x_u31.g1_int1)=6.408129969003723e-07
.nodeset v(xu10_j2.x_u32.g1_int1)=29.776132791814639
.nodeset v(xu10_j2.x_u35.g1_int1)=0
.nodeset v(xu10_j2.x_u36.3)=0
.nodeset v(xu10_j2.x_u36.5)=0
.nodeset v(xu10_j2.x_u37.3)=0
.nodeset v(xu10_j2.x_u37.5)=0
.nodeset v(xu10_j2.x_u4.e1_int1)=1.2449999999999999e-05
.nodeset v(xu10_j2.x_u6.g1_int1)=0.87293377529179506
.temp 27

V5 v5 0 DC 5
V3 v3 0 DC 3.3
VN vn3 0 DC -3.01244
R200 v5 v5afe 4.7
C156 v5afe 0 4.7u
C157 v5afe 0 4.7u
* Nine unsimulated front buffers: explicit nominal 1.3mA DC rail load EACH.
* This load is an assumption, not a full ten-channel coupling simulation.
Iother v5afe vn3 11.7m
Voff off 0 DC 0.968992248062

* Actual J2 values; source resistance is generator, not board termination.
Vsig_j2 src_j2 0 DC 2 AC 1
Rsource_j2 src_j2 raw_j2 50
R177_j2 raw_j2 0 100000
R140_j2 raw_j2 filt_j2 3320
C97_j2 filt_j2 0 10n
XU20_j2 filt_j2 buf_j2 v5afe vn3 buf_j2 OPAx189
C120_j2 v5afe 0 100n
C121_j2 vn3 0 100n
R137_j2 buf_j2 sum_j2 4000
XU10_j2 off sum_j2 v3 0 drv_j2 OPAx320-Q1
C100_j2 v3 0 100n
R187_j2 sum_j2 drv_j2 2800
C122_j2 sum_j2 drv_j2 10n
R141_j2 drv_j2 adc_j2 47
C80_j2 adc_j2 0 10n

.save v(raw_j2) v(filt_j2) v(buf_j2) v(drv_j2) v(adc_j2) v(off) v(ref25) v(v5afe) i(v5) i(v3) i(vn)
.save @c97_j2[i] @c122_j2[i] @c80_j2[i] @c156[i] @c157[i]
.op
.end
