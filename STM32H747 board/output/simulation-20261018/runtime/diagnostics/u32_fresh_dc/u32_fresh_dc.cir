Original TI OPA189 standalone U32, single 5 V rail, 0.969 V follower
.include "C:/Dev/EasyEDA/EasyEDA-Project/STM32H747 board/output/simulation-20261018/models/OPA189/OPAx189.LIB"
.options reltol=1e-5 abstol=1e-12 vntol=1e-7 itl1=500 itl4=1000
.nodeset v(xu32.n3294772)=0.018353406257698379
.nodeset v(xu32.n2991553)=0.0014998394229114951
.nodeset v(xu32.n3294626)=0.092892997404305788
.nodeset v(xu32.n3294630)=0.03066105285803452
.nodeset v(xu32.n2992397)=4.9999949965143378
.nodeset v(xu32.n2992375)=0.0014995485891615081
.nodeset v(xu32.n2992413)=1.498175004012278e-09
.nodeset v(xu32.n2991741)=0.001499548589161595
.nodeset v(xu32.mid)=0.0014995485891615081
.nodeset v(xu32.n2991765)=0.001499548589161595
.nodeset v(xu32.n2991811)=0.001499548589161595
.nodeset v(xu32.n2991831)=0.001499548589161595
.nodeset v(xu32.n3294812)=0.00062307740937353072
.nodeset v(xu32.n2991579)=0.001499472331044877
.nodeset v(xu32.n2991907)=0.001499548589161595
.nodeset v(xu32.n2991925)=0.001499548589161595
.nodeset v(xu32.n2991969)=0.96997961274294253
.nodeset v(xu32.n2992033)=4.9827410205588478
.nodeset v(xu32.n2992029)=0.037875297049786837
.nodeset v(xu32.n2992093)=0.001499545282621159
.nodeset v(xu32.n2992099)=0.001499544931801864
.nodeset v(xu32.sw_ol_opax189)=0.0014995485891615081
.nodeset v(xu32.vimon)=0.0024684649397386238
.nodeset v(xu32.vout_s)=0.96899897037357463
.nodeset v(xu32.n2991657)=0.96899896818998776
.nodeset v(xu32.clamp)=0.9699796130702073
.nodeset v(xu32.vclp)=0.97003914157648086
.nodeset v(xu32.n4031911)=0.97003914025587001
.nodeset v(xu32.n3827259)=10.69262433826238
.nodeset v(xu32.n3828449)=0.054955330661984353
.nodeset v(xu32.n3850714)=0.0015265154718653729
.nodeset v(xu32.n3850724)=0.001500019945726395
.nodeset v(xu32.n3850734)=0.0036654319831654898
.nodeset v(xu32.n3850744)=0.0015000199631525211
.nodeset v(xu32.n39464171)=0.96998030815554759
.nodeset v(xu32.n39483181)=0.9699798035284144
.nodeset v(xu32.n3957003)=10.6936720637808
.nodeset v(xu32.n3957013)=1.5518674057991411
.nodeset v(xu32.n4029618)=1.284704374994335
.nodeset v(xu32.n4029628)=0.97003913871124914
.nodeset v(xu32.n3294524)=0.97003914154896609
.nodeset v(xu32.n40409811)=10.69445902850879
.nodeset v(xu32.n4053611)=0.001500691199709011
.nodeset v(xu32.n2991581)=0.001500019905443184
.nodeset v(xu32.n40636261)=10.694590260839631
.nodeset v(xu32.n40688271)=10.693687996182859
.nodeset v(xu32.n40719131)=10.6936880036522
.nodeset v(xu32.esdp)=0.96899999834390205
.nodeset v(xu32.esdn)=0.96899896905750482
.nodeset v(xu32.n2992163)=0.96899896906124061
.nodeset v(xu32.n3294618)=0.97003914154896653
.nodeset v(xu32.cl_clamp)=0.97003914154896653
.nodeset v(xu32.claw_clamp)=0.97003914154896631
.nodeset v(xu32.n3201092)=10.694060842307749
.nodeset v(xu32.vcc_b)=4.9999950015128336
.nodeset v(xu32.vee_b)=1.4966753670111099e-09
.nodeset v(xu32.n2991563)=0.96899842067403841
.nodeset v(xu32.n2991555)=0.968998129913902
.nodeset v(xu32.vcc_clp)=4.9827410155776066
.nodeset v(xu32.vee_clp)=0.037875297013411087
.nodeset v(xu32.n2992299)=-2.3299608551169788
.nodeset v(xu32.n2992295)=-2.3299608584235201
.nodeset v(xu32.n2992323)=4.6200391379191208
.nodeset v(xu32.n2992331)=4.6200391415764814
.nodeset v(xu32.n2992235)=0.96899896906124061
.nodeset v(xu32.n3946385)=0.96997961279839395
.nodeset v(xu32.vsense)=0.96997961274294286
.nodeset v(xu32.n2991587)=0.96899896824843668
.nodeset v(xu32.n2991583)=0.96899842067403841
.nodeset v(xu32.n3948252)=0.96997975364764699
.nodeset v(xu32.n3946395)=0.96997975364426092
.nodeset v(xu32.n3957077)=10.693688994210691
.nodeset v(xu32.n3948270)=0.96997976966732724
.nodeset v(xu32.n4040957)=10.694379391670241
.nodeset v(xu32.n4040935)=10.69437939126858
.nodeset v(xu32.n4063590)=10.69458624428402
.nodeset v(xu32.n4068803)=10.69368819577805
.nodeset v(xu32.n4068781)=10.693688195788431
.nodeset v(xu32.n4071867)=10.693688107400151
.nodeset v(xu32.n2991573)=0.96899999834390205
.nodeset v(xu32.n2991619)=0.96899896905750482
.nodeset v(xu32.n2991623)=2.499995001512834
.nodeset v(xu32.n2991635)=-0.099999998503324639
.nodeset v(xu32.n2991643)=0.96899896819004616
.nodeset v(xu32.n2991667)=0.0014994618374686299
.nodeset v(xu32.n3294682)=10.692461493903229
.nodeset v(xu32.n2991729)=0.001499548589161595
.nodeset v(xu32.n2991763)=0.001499548589161595
.nodeset v(xu32.n2991807)=69.401499548589172
.nodeset v(xu32.n2991809)=0.001499548589161595
.nodeset v(xu32.n2991837)=0.001499548589161595
.nodeset v(xu32.n2991849)=-69.998500451410834
.nodeset v(xu32.n2991901)=90.001499548589166
.nodeset v(xu32.n2991905)=0.001499548589161595
.nodeset v(xu32.n2991931)=0.001499548589161595
.nodeset v(xu32.n2991943)=-89.998500451410834
.nodeset v(xu32.n2991997)=4.9827410205588363
.nodeset v(xu32.n2992001)=0.037875297049789897
.nodeset v(xu32.v11)=0.001499545282621159
.nodeset v(xu32.v12)=0.001499544931801864
.nodeset v(xu32.n2992105)=0.0014995485891615081
.nodeset v(xu32.n2992151)=0.002468914986091635
.nodeset v(xu32.n2992287)=4.6200391379191208
.nodeset v(xu32.n2992267)=-2.3299608551169788
.nodeset v(xu32.x_u10.gvo+_int1)=0
.nodeset v(xu32.x_u10.gvo-_int1)=0
.nodeset v(xu32.x_u11.gvo+_int1)=0
.nodeset v(xu32.x_u11.gvo-_int1)=0
.nodeset v(xu32.x_u12.gvo+_int1)=0
.nodeset v(xu32.x_u12.gvo-_int1)=0
.nodeset v(xu32.x_u16.gsw+_int1)=0
.nodeset v(xu32.x_u18.g1_int1)=1.7253992363593628e-05
.nodeset v(xu32.x_u18.g1_int2)=0.00096891635057711574
.nodeset v(xu32.x_u19.g1_int1)=3.7875298616248237e-05
.nodeset v(xu32.x_u19.g1_int2)=-0.00096891635057711574
.nodeset v(xu32.x_u22.g1_int1)=0
.nodeset v(xu32.x_u23.g1_int1)=0
.nodeset v(xu32.x_u26.g1_int1)=9.689163505771157e-07
.nodeset v(xu32.x_u27.g1_int1)=0
.nodeset v(xu32.x_u30.g1_int1)=-8.675170499496121e-14
.nodeset v(xu32.x_u31.g1_int1)=-3.1040796732127729e-07
.nodeset v(xu32.x_u32.g1_int1)=10.691156414564571
.nodeset v(xu32.x_u35.g1_int1)=0
.nodeset v(xu32.x_u36.3)=0
.nodeset v(xu32.x_u36.5)=0
.nodeset v(xu32.x_u37.3)=0
.nodeset v(xu32.x_u37.5)=0
.nodeset v(xu32.x_u4.e1_int1)=-1.86843e-06
.nodeset v(xu32.x_u40.5)=0
.nodeset v(xu32.x_u6.g1_int1)=0.96749941965927522
.temp 27
VP vp 0 5
VI vi 0 0.969
XU32 vi off vp 0 off OPAx189
RL off 0 1meg
.save all
.op
.end
