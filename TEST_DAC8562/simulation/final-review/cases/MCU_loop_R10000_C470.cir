Final-current-netlist analog screening MCU_loop_R10000_C470
.include "../../models/pspice/OPAx277.LIB"
.options reltol=1e-5 abstol=1e-10 vntol=1e-7 itl1=500 itl4=500
VCC vp 0 11.97231
VEE vn 0 -12.13
VREF ref 0 1.65
VIN input 0 DC 1.65
RS input received 1000
RBIAS received ref 10meg
XBUF received buffered vp vn buffered OPAx277
RI buffered plus 14000
RG plus 0 100000
RR ref mix 14000
RF sense mix 100000
VLOOP minus mix DC 0 AC 1
XAMP plus minus vp vn raw OPAx277
RISO raw sense 100
CF raw mix 22p
RCONTACT sense out .1
COUT out 0 100p
RL out 0 10000
CCABLE out 0 470p
.nodeset v(raw)=0 v(sense)=0 v(out)=0 v(plus)=1.4473684210526316 v(mix)=1.4473684210526316 v(buffered)=1.65 v(received)=1.65 v(minus)=1.4473684210526316
.control
set wr_singlescale
set wr_vecnames
set numdgt=12
ac dec 150 10 100meg
let gd=db(-v(mix)/v(minus))
let pd=cph(-v(mix)/v(minus))*180/PI
wrdata results/MCU_loop_R10000_C470.dat gd pd
quit
.endc
.end
