DAC8562 high-Z stability design comparison dfb_100_22_tran_r1000000_c5000_v4.925
.include "models/pspice/OPAx277.LIB"
.options reltol=1e-5 abstol=1e-10 vntol=1e-7 itl1=500 itl4=500
VCC vp 0 11.97231
VEE vn 0 -12.13
VREF ref 0 2.5
VDAC dac 0 PWL(0 2.5 50u 2.5 150u 4.925 500u 4.925 500.02u 4.95 700u 4.95 700.02u 4.925 950u 4.925)
RI dac plus 24900
RG plus 0 100000
RR ref mix 24900
RF out mix 100000
XU4 plus mix vp vn raw OPAx277
RISO raw out 100
CF raw mix 2.1999999999999998e-11
COUT out 0 100p
RL out 0 1000000
CCABLE out 0 5000p
.nodeset v(raw)=0 v(out)=0 v(plus)=2.00160128 v(mix)=2.00160128
.control
set wr_singlescale
set wr_vecnames
set numdgt=12
tran 20n 950u 0 20n
wrdata highz/results/dfb_100_22_tran_r1000000_c5000_v4.925.dat v(dac) v(out) v(raw)
quit
.endc
.end
