DAC8562 high-Z stability design comparison dfb_100_22_loop_r1000000_c5000_v0.05
.include "models/pspice/OPAx277.LIB"
.options reltol=1e-5 abstol=1e-10 vntol=1e-7 itl1=500 itl4=500
VCC vp 0 11.97231
VEE vn 0 -12.13
VREF ref 0 2.5
VDAC dac 0 DC 0.05
RI dac plus 24900
RG plus 0 100000
RR ref mix 24900
RF out mix 100000
VLOOP minus mix DC 0 AC 1
XU4 plus minus vp vn raw OPAx277
RISO raw out 100
CF raw mix 2.1999999999999998e-11
COUT out 0 100p
RL out 0 1000000
CCABLE out 0 5000p
.nodeset v(raw)=-9.84034136546185 v(out)=-9.839357429718877 v(plus)=0.040032025620496396 v(mix)=0.040032025620496396 v(minus)=0.040032025620496396
.control
set wr_singlescale
set wr_vecnames
set numdgt=12
ac dec 200 10 100meg
let lg=-v(mix)/v(minus)
let gd=db(lg)
let pd=cph(lg)*180/PI
wrdata highz/results/dfb_100_22_loop_r1000000_c5000_v0.05.dat gd pd
quit
.endc
.end
